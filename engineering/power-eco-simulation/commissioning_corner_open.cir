commissioning_corner_open
* BEHAVIORAL SCREEN -- not a manufacturer macro-model or hardware qualification.
* Board source SHA256 0bf6c0e2ce4ebc145ef74c235069d32af225fef8908c4aa59ae970d82577f727
.options reltol=1e-5 abstol=1e-9 vntol=1e-7 method=gear maxord=2
.param Cbulk=0.000752 Vinitial=53.7500982283
Cbulk cap 0 {Cbulk} ic={Vinitial}
Resr cap bus 0.01
Rleak bus 0 1e9
Rsense bus sense 1k
Csense sense 0 1e-10 ic={Vinitial}
Vbrake bus rb 0
Rbrake rb drain 1000000000000.0
Sbrake drain 0 sense 0 BRK
.model BRK SW(Ron=0.0302 Roff=1e12 Vt=52.2188202096 Vh=0.3234)
Dloa 0 loa BODY
La loa wa 0.0042 ic=0.8772662556209577
Rwa wa hia .48
Dhia hia reta BODY
Vreta reta bus 0
Rfloatloa loa 0 1G
Rfloathia hia 0 1G
Dlob 0 lob BODY
Lb lob wb 0.0042 ic=0.8772662556209577
Rwb wb hib .48
Dhib hib retb BODY
Vretb retb bus 0
Rfloatlob lob 0 1G
Rfloathib hib 0 1G
.model BODY D(Is=1e-9 N=1.2 Rs=.015 Cjo=330p)
.tran 5e-08 0.003 0 5e-08 uic
.end
