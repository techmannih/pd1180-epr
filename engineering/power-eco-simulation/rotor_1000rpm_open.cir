rotor_1000rpm_open
* BEHAVIORAL SCREEN -- not a manufacturer macro-model or hardware qualification.
* Board source SHA256 a96c1a3061d3659739ac42cdd1ee8892e02deb28f5108e5790e2c4b2c5596a8a
.options reltol=1e-5 abstol=1e-9 vntol=1e-7 method=gear maxord=2
.param Cbulk=0.000752 Vinitial=48
Cbulk cap 0 {Cbulk} ic={Vinitial}
Resr cap bus 0.01
Rleak bus 0 1e9
Rsense bus sense 1k
Csense sense 0 1e-10 ic=48
Vbrake bus rb 0
Rbrake rb drain 1000000000000.0
Sbrake drain 0 sense 0 BRK
.model BRK SW(Ron=0.0302 Roff=1e12 Vt=51.6666 Vh=0.3234)
Bregen 0 inj I = (time >= 0.001 && time <= 0.021) ? (76.7635897863*(1-(time-0.001)/0.02)/max(v(bus),1)) : 0
Vregen inj bus 0
.tran 5e-07 0.03 0 5e-07 uic
.end
