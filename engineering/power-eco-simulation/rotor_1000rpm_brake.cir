rotor_1000rpm_brake
* BEHAVIORAL SCREEN -- not a manufacturer macro-model or hardware qualification.
* Board source SHA256 60c10dd30c1f5295c6672af61172b489f94b0c31149f214bc4731d08fbcec45e
.options reltol=1e-5 abstol=1e-9 vntol=1e-7 method=gear maxord=2
.param Cbulk=0.000752 Vinitial=48
Cbulk cap 0 {Cbulk} ic={Vinitial}
Resr cap bus 0.01
Rleak bus 0 1e9
Rsense bus sense 1k
Csense sense 0 1e-10 ic=48
Vbrake bus rb 0
Rbrake rb drain 10
Sbrake drain 0 sense 0 BRK
.model BRK SW(Ron=0.0302 Roff=1e12 Vt=52.3953239188 Vh=0.248410022422)
Bregen 0 inj I = (time >= 0.001 && time <= 0.021) ? (76.7635897863*(1-(time-0.001)/0.02)/max(v(bus),1)) : 0
Vregen inj bus 0
.tran 5e-07 0.03 0 5e-07 uic
.end
