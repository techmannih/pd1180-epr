applied_full_current_brake_100us_lag
* BEHAVIORAL SCREEN -- not a manufacturer macro-model or hardware qualification.
* Model basis 16d1347fc9991399f7ff5ea089966af2876fc3ad
* Current source SHA256 6ea5b06f6d4726b842435730d5358935b642542a6e611cb8d3a42db938acedcc
.options reltol=1e-5 abstol=1e-9 vntol=1e-7 method=gear maxord=2
.param Cbulk=0.000752 Vinitial=53.8258593494
Cbulk cap 0 {Cbulk} ic={Vinitial}
Resr cap bus 0.01
Rleak bus 0 1e9
Rsense bus sense 1k
Csense sense 0 1e-07 ic={Vinitial}
Vbrake bus rb 0
Rbrake rb drain 10
Sbrake drain 0 sense 0 BRK
.model BRK SW(Ron=0.0302 Roff=1e12 Vt=52.3953239188 Vh=0.248410022422)
Dloa 0 loa BODY
La loa wa 0.0042 ic=5.7125991733
Rwa wa hia .48
Dhia hia reta BODY
Vreta reta bus 0
Rfloatloa loa 0 1G
Rfloathia hia 0 1G
Dlob 0 lob BODY
Lb lob wb 0.0042 ic=5.7125991733
Rwb wb hib .48
Dhib hib retb BODY
Vretb retb bus 0
Rfloatlob lob 0 1G
Rfloathib hib 0 1G
Bregen 0 inj I=(time<=100u) ? (0*(1-time/100u)/max(v(bus),1)) : 0
Vregen inj bus 0
.model BODY D(Is=1e-9 N=1.2 Rs=.015 Cjo=330p)
.tran 1e-07 0.003 0 1e-07 uic
.end
