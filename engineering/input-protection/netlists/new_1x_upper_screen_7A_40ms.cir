new_1x_upper_screen_7A_40ms
* BEHAVIORAL SCREEN -- not a manufacturer macro-model or hardware qualification.
* Model basis 16d1347fc9991399f7ff5ea089966af2876fc3ad
* Current source SHA256 6ea5b06f6d4726b842435730d5358935b642542a6e611cb8d3a42db938acedcc
.options reltol=1e-5 abstol=1e-9 vntol=1e-7 method=gear maxord=2
* 48 V source; 100 mOhm source/cable R and 2.2 uF input C are assumptions.
* Upstream logic is represented by a constant 250 mA load above 10 V.
* Initial capacitors are precharged: this is an overload test, not startup.
Videal ideal 0 48
Bsource ideal src I = (v(trip) < .5) ? min(12,max(0,(48-v(vin))/0.1)) : 0
Vsource src vin 0
Cinput vin 0 2.2u ic=47.775
Rleakin vin 0 1G
Blogic vin 0 I=0.25*min(1,max(v(vin),0)/10)
Bpath vin feed I = (v(uv) > .5) ? 0 : min(((time >= 0.005 && time < 0.0305) ? 4.00178178736 : 4.00178178736),max(0,(v(vin)-v(bus))/0.0461))
Vfeed feed bus 0
Cbulk cap 0 940u ic=47.6828
Resr cap bus .01
Rleakout bus 0 1G
Bload bus 0 I = (v(uv) > .5) ? 0 : (((time >= 0.005 && time < 0.045) ? 7 : 2)*min(1,max(v(bus),0)/10))
* Below 10 V the synthetic load folds back; post-collapse values are illustrative.
Vtrip trip 0 0
Vuv uv 0 0
.tran 1e-06 0.06 0 1e-06 uic
.end
